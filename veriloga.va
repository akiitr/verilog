`include "constants.vams"
`include "disciplines.vams"

module NTFET(d,g,s);
inout d,g,s;
electrical g,d,s;
real Ids, Cgs, Cgd,Qg, Qs, Qd, Cds;
real Cgs_tmp,Cgd_tmp,Cds_tmp,Csg_tmp,Cdg_tmp,Csd_tmp;
parameter real W=1 from (0:inf);
integer direction;
branch (g, s) cgs;
analog begin

begin
Ids=$table_model(V(d,s), (V(g,s)), "IdVg-NFET1.tbl","1L,1L");
Cgd_tmp=$table_model(V(d,s), (V(g,s)), "CGD-NFET-Lg-16nm.tbl","1C,1C");
Cgs_tmp=$table_model(V(d,s), (V(g,s)), "CGS-NFET-Lg-16nm.tbl","1C,1C");
Cds_tmp=$table_model(V(d,s), (V(g,s)), "CDS-NFET-Lg-16nm.tbl","1C,1C");
direction =-1;
end

if(analysis("tran"))
begin
Cgd=/*abs*/0.9*(Cgd_tmp);
Cgs=/*abs*/0.9*(Cgs_tmp);
Cds=/*abs*/0.9*(Cds_tmp);
Qd = (-1*W*Cgd)*(V(g,d));
Qs = (-1*W*Cgs)*(V(g,s));
Qg=-1*(Qd+Qs);
I(d,s) <+ direction*Ids*W ;
I(d) <+ ddt(Qd);
I(s) <+ ddt(Qs);
I(g) <+ ddt(Qg);
I(cgs) <+ Cgs*ddt(V(cgs));
end

else
begin
I(d,s) <+ direction*Ids*W;
end

end
endmodule
